ADE simulation setup
Run mode: Single Run, Sweeps and Corners
Tests:
  TX:test:1: TX/test/schematic, simulator spectre
Global variables:
  x = 10:1:20
  fs = 1G
  fs1 = 14G
Corners (nominal off):
  model folders: /home/tsmcN28_CRN28HPCP/models/spectre
  TT: temperature=27; toplevel.scs[top_tt]
  FF (off): temperature=0; toplevel.scs[top_ff]
  SS (off): temperature=100; toplevel.scs[top_ss]
